* AND2, input AB = 10 - Part B SPICE reference, 200 corners, sampling done entirely inside ngspice
* Transistors are the dataset netlists' devices, called as subcircuits from Datasets/netlists/*.sub
* Transistor states for this input: Xpa=pmos_off, Xpb=pmos_on, Xna=nmos_on, Xnb=nmos_off, Xpi=pmos_off, Xni=nmos_on
* Run (from this folder):  ngspice -b AND2_10.cir      Output: ../data/spice_AND2_10.csv
* Leakage = current drawn from the VDD supply.
.options gmin=1e-18 abstol=1e-18 reltol=1e-6 vntol=1e-9
.include ../../Datasets/netlists/nmos_off.sub
.include ../../Datasets/netlists/nmos_on.sub
.include ../../Datasets/netlists/pmos_off.sub
.include ../../Datasets/netlists/pmos_on.sub

* ---- supply and inputs (inputs at exactly 0 or VDD) ----
Vdd vdd 0 dc 1
Va a 0 dc 0
Vb b 0 dc 0

* ---- AND2 = NAND2 (output n, internal node x) followed by INV (input n, output out), one complete gate ----
Xpa n a vdd vdd pmos_off w=88n
Xpb n b vdd vdd pmos_on w=88n
Xna n a x 0 nmos_on w=88n
Xnb x b 0 0 nmos_off w=88n
Xpi out n vdd vdd pmos_off w=88n
Xni out n 0 0 nmos_on w=44n

.control
set rndseed=7                    $ same seed in every Part B netlist -> the same 200 corners for every gate and input
option numdgt=10
echo "corner,A,B,vdd,temp,n_vth0,n_toxe,n_ndep,n_u0,n_xj,p_vth0,p_toxe,p_ndep,p_u0,p_xj,leak,v_int,v_n,v_out" > ../data/spice_AND2_10.csv
let c = 0
while c < 200
  * ---- draw one corner (sunif(0) is uniform in -1..1) ----
  let vdd = 1.0*(1 + 0.1*sunif(0))              $ assigned VDD = 1 V, +-10 %
  let temp = 42.5 + 82.5*sunif(0)               $ -40 .. 125 C
  * NMOS process parameters (nominal from 22nm_HP.pm, +-10 %), shared by all NMOS in the gate
  let n_vth0 = 0.50308*(1 + 0.1*sunif(0))
  let n_toxe = 1.05e-09*(1 + 0.1*sunif(0))
  let n_ndep = 5.5e+18*(1 + 0.1*sunif(0))
  let n_u0 = 0.04*(1 + 0.1*sunif(0))
  let n_xj = 7.2e-09*(1 + 0.1*sunif(0))
  * PMOS process parameters (nominal from 22nm_HP.pm, +-10 %), shared by all PMOS in the gate
  let p_vth0 = -0.4606*(1 + 0.1*sunif(0))
  let p_toxe = 1.1e-09*(1 + 0.1*sunif(0))
  let p_ndep = 4.4e+18*(1 + 0.1*sunif(0))
  let p_u0 = 0.0095*(1 + 0.1*sunif(0))
  let p_xj = 7.2e-09*(1 + 0.1*sunif(0))
  * ---- apply the corner ----
  alter vdd dc = $&vdd
  option temp = $&temp
  altermod nmos vth0 = $&n_vth0 toxe = $&n_toxe ndep = $&n_ndep u0 = $&n_u0 xj = $&n_xj
  altermod pmos vth0 = $&p_vth0 toxe = $&p_toxe ndep = $&p_ndep u0 = $&p_u0 xj = $&p_xj
  * ---- this input: A = 1, B = 0 ----
  let ia = 1
  let ib = 0
  let va = ia*vdd
  alter va dc = $&va
  let vb = ib*vdd
  alter vb dc = $&vb
  op
  let leak = -i(vdd)
  let vint = v(x)
  let vnn = v(n)
  let vout = v(out)
  echo "$&c,$&ia,$&ib,$&vdd,$&temp,$&n_vth0,$&n_toxe,$&n_ndep,$&n_u0,$&n_xj,$&p_vth0,$&p_toxe,$&p_ndep,$&p_u0,$&p_xj,$&leak,$&vint,$&vnn,$&vout" >> ../data/spice_AND2_10.csv
  destroy all
  let c = c + 1
end
.endc
.end
