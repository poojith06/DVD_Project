* PMOS OFF - dataset generation entirely inside ngspice (PRECISE ig/ib version)
* Same circuit and same input distributions (rndseed=15) as Datasets/netlists/pmos_off_ngspice.cir
* (this ngspice build draws a different random stream, so rows are not identical to the original CSV).
* Only change: ig and ib are read from BSIM4's own computed currents instead of the gate/body
* voltage-source branch currents. The source currents are rounded to steps of ~2.2e-16 A
* (double precision of the circuit solve), while PMOS OFF ig is only ~1e-16..1e-13 A.
*   ig = -(igs + igd + igb + igcs + igcd)
*   ib = -(ibd + ibs) + igb + isub + igidl + igisl
* Both equal -i(vg) / -i(vb) to within 5e-5 wherever those are large enough to be resolved.
* id and is are still -i(vd) / -i(vs) (they are not quantised).
* pmos_off_source_readout.csv keeps the old -i(vg), -i(vb) per row, only to compare the two readouts.
* Model: 22nm_HP.pm (PTM HP 22nm)
* Run:  ngspice_con -b pmos_off_ngspice.cir   -> writes ../data/pmos_off.csv
.options gmin=1e-18 abstol=1e-18 reltol=1e-6 vntol=1e-9
.include ../../../model/22nm_HP.pm

Vd d 0 dc 0
Vg g 0 dc 0
Vs s 0 dc 0
Vb b 0 dc 0
M1 d g s b pmos L=22n W=44n

.control
set rndseed=15
let n = 10000                    $ number of samples
echo "vdd,temp,w,vd,vs,vg,vb,vth0,toxe,ndep,u0,xj,id,ig,is,ib" > ../data/pmos_off.csv
echo "ig_source,ib_source" > ../data/pmos_off_source_readout.csv
let k = 0
while k < n
  * ---- assigned / nominal values (PMOS values from 22nm_HP.pm) ----
  let lmin = 22e-9
  let vdd_nom = 1.0              $ assigned nominal VDD = 1 V
  let vth0_nom = -0.4606
  let toxe_nom = 1.1e-9
  let ndep_nom = 4.4e18
  let u0_nom = 0.0095
  let xj_nom = 7.2e-9
  * ---- draw one random sample (sunif(0) is uniform in -1..1) ----
  let vdd = vdd_nom*(1 + 0.1*sunif(0))
  let t = 42.5 + 82.5*sunif(0)
  let w = lmin*(4.5 + 3.5*sunif(0))
  let vd = vdd*(0.5 + 0.5*sunif(0))
  let vs = vdd*(0.5 + 0.5*sunif(0))
  let vg = vdd
  let vb = vdd
  let p1 = vth0_nom*(1 + 0.1*sunif(0))
  let p2 = toxe_nom*(1 + 0.1*sunif(0))
  let p3 = ndep_nom*(1 + 0.1*sunif(0))
  let p4 = u0_nom*(1 + 0.1*sunif(0))
  let p5 = xj_nom*(1 + 0.1*sunif(0))
  * ---- apply the sample to the circuit ----
  alter vd dc = $&vd
  alter vs dc = $&vs
  alter vg dc = $&vg
  alter vb dc = $&vb
  alter m1 w = $&w
  * one parameter per altermod line (ngspice applies only the first parameter on a line)
  altermod pmos vth0 = $&p1
  altermod pmos toxe = $&p2
  altermod pmos ndep = $&p3
  altermod pmos u0 = $&p4
  altermod pmos xj = $&p5
  option temp = $&t
  * ---- simulate and append one CSV row (currents INTO each terminal) ----
  op
  let cid = -i(vd)
  let cig = -(@m1[igs] + @m1[igd] + @m1[igb] + @m1[igcs] + @m1[igcd])
  let cis = -i(vs)
  let ig_src = -i(vg)
  let ib_src = -i(vb)
  let cib = -(@m1[ibd] + @m1[ibs]) + @m1[igb] + @m1[isub] + @m1[igidl] + @m1[igisl]
  echo "$&vdd,$&t,$&w,$&vd,$&vs,$&vg,$&vb,$&p1,$&p2,$&p3,$&p4,$&p5,$&cid,$&cig,$&cis,$&cib" >> ../data/pmos_off.csv
  echo "$&ig_src,$&ib_src" >> ../data/pmos_off_source_readout.csv
  destroy all
  let k = k + 1
end
.endc
.end
