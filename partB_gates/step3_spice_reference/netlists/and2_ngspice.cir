* AND2 - Part B SPICE reference, generation entirely inside ngspice
* Model: 22nm_HP.pm (PTM HP 22nm)   Run (from this folder):  ngspice_con -b and2_ngspice.cir  -> ../data/and2.csv
* 200 random PVT corners x every input combination. A corner is one random draw of VDD, temperature and
* process parameters (VDD nominal +-10 %, T uniform -40..125 C, vth0/toxe/ndep/u0/xj nominal +-10 %),
* one draw shared by all NMOS and a separate draw shared by all PMOS. Inputs at exactly 0 or VDD.
* Leakage = current drawn from the VDD supply (Vsup).
.options gmin=1e-18 abstol=1e-18 reltol=1e-6 vntol=1e-9
.include ../../../model/22nm_HP.pm

* ---- supply and inputs ----
Vsup vdd 0 dc 1
Va a 0 dc 0
Vb b 0 dc 0
* ---- AND2 = NAND2 (output n, internal node x) + INV (n -> out), simulated as one gate ----
* transistor widths: NAND2 part NMOS 88n, PMOS 88n, INV NMOS 44n, PMOS 88n
Mpa n   a vdd vdd pmos L=22n W=88n
Mpb n   b vdd vdd pmos L=22n W=88n
Mna n   a x   0   nmos L=22n W=88n
Mnb x   b 0   0   nmos L=22n W=88n
Mpi out n vdd vdd pmos L=22n W=88n
Mni out n 0   0   nmos L=22n W=44n

.control
set rndseed=16
let ncorner = 200                      $ number of PVT corners (same 200 as Part C)
echo "corner,A,B,vdd,temp,n_vth0,n_toxe,n_ndep,n_u0,n_xj,p_vth0,p_toxe,p_ndep,p_u0,p_xj,leak,v_int,v_n,v_out" > ../data/and2.csv
let c = 0
while c < ncorner
  * ---- assigned / nominal values (from 22nm_HP.pm) ----
  let vdd_nom = 1
  let n_vth0_nom = 0.50308
  let n_toxe_nom = 1.05e-9
  let n_ndep_nom = 5.5e18
  let n_u0_nom = 0.04
  let n_xj_nom = 7.2e-9
  let p_vth0_nom = -0.4606
  let p_toxe_nom = 1.1e-9
  let p_ndep_nom = 4.4e18
  let p_u0_nom = 0.0095
  let p_xj_nom = 7.2e-9
  * ---- draw one random corner (sunif(0) is uniform in -1..1), VDD first ----
  * (same block, order and seed as partC_cla/step6_spice_reference/netlists/cla3_ngspice.cir -> same 200 corners)
  let vdd = vdd_nom*(1 + 0.1*sunif(0))
  let t = 42.5 + 82.5*sunif(0)
  let n1 = n_vth0_nom*(1 + 0.1*sunif(0))
  let n2 = n_toxe_nom*(1 + 0.1*sunif(0))
  let n3 = n_ndep_nom*(1 + 0.1*sunif(0))
  let n4 = n_u0_nom*(1 + 0.1*sunif(0))
  let n5 = n_xj_nom*(1 + 0.1*sunif(0))
  let p1 = p_vth0_nom*(1 + 0.1*sunif(0))
  let p2 = p_toxe_nom*(1 + 0.1*sunif(0))
  let p3 = p_ndep_nom*(1 + 0.1*sunif(0))
  let p4 = p_u0_nom*(1 + 0.1*sunif(0))
  let p5 = p_xj_nom*(1 + 0.1*sunif(0))
  * ---- apply the corner: all NMOS share one set, all PMOS share another ----
  * one parameter per altermod line (ngspice applies only the first parameter on a line)
  alter vsup dc = $&vdd
  altermod nmos vth0 = $&n1
  altermod nmos toxe = $&n2
  altermod nmos ndep = $&n3
  altermod nmos u0 = $&n4
  altermod nmos xj = $&n5
  altermod pmos vth0 = $&p1
  altermod pmos toxe = $&p2
  altermod pmos ndep = $&p3
  altermod pmos u0 = $&p4
  altermod pmos xj = $&p5
  option temp = $&t
  * ---- every input combination: AB = 00, 01, 10, 11 (0 -> 0 V, 1 -> VDD) ----
  let ia = 0
  while ia < 2
    let va = ia*vdd
    alter va dc = $&va
    let ib = 0
    while ib < 2
      let vb = ib*vdd
      alter vb dc = $&vb
      op
      let leak = -i(vsup)               $ leakage drawn from the VDD supply
      let vint = v(x)
      let vn = v(n)
      let vout = v(out)
      echo "$&c,$&ia,$&ib,$&vdd,$&t,$&n1,$&n2,$&n3,$&n4,$&n5,$&p1,$&p2,$&p3,$&p4,$&p5,$&leak,$&vint,$&vn,$&vout" >> ../data/and2.csv
      destroy all
      let ib = ib + 1
    end
    let ia = ia + 1
  end
  let c = c + 1
end
.endc
.end
