.options gmin=1e-18 abstol=1e-18 reltol=1e-6 vntol=1e-9
.include ../../Gates_Part-B/netlists/22nm_HP.pm
.include ../../Gates_Part-B/netlists/corners.inc
.include cla3.sub

* supply and inputs
Vsup vdd 0 dc 1
Va0 a0 0 dc 0
Va1 a1 0 dc 0
Va2 a2 0 dc 0
Vb0 b0 0 dc 0
Vb1 b1 0 dc 0
Vb2 b2 0 dc 0
* 3-bit CLA
xcla cout s2 s1 s0 a2 a1 a0 b2 b1 b0 vdd 0 CLA3

.control
echo "corner,A,B,A2,A1,A0,B2,B1,B0,vdd,temp,n_vth0,n_toxe,n_ndep,n_u0,n_xj,p_vth0,p_toxe,p_ndep,p_u0,p_xj,leak,v_g0_bar,v_g0,v_g1_bar,v_g1,v_g2_bar,v_g2,v_p1,v_p2,v_t1_bar,v_c2,v_t2_bar,v_t3,v_p21,v_t4,v_s0,v_s1,v_s2,v_cout" > ../data/cla3.csv
let c = 0
while c < 200
  *  read corner c
  let vdd    = c_vdd[c]
  let temp   = c_temp[c]
  let n_vth0 = c_n_vth0[c]
  let n_toxe = c_n_toxe[c]
  let n_ndep = c_n_ndep[c]
  let n_u0   = c_n_u0[c]
  let n_xj   = c_n_xj[c]
  let p_vth0 = c_p_vth0[c]
  let p_toxe = c_p_toxe[c]
  let p_ndep = c_p_ndep[c]
  let p_u0   = c_p_u0[c]
  let p_xj   = c_p_xj[c]
  * apply it: all NMOS share one set, all PMOS share another
  alter vsup dc = $&vdd
  option temp = $&temp
  altermod nmos vth0 = $&n_vth0 toxe = $&n_toxe ndep = $&n_ndep u0 = $&n_u0 xj = $&n_xj
  altermod pmos vth0 = $&p_vth0 toxe = $&p_toxe ndep = $&p_ndep u0 = $&p_u0 xj = $&p_xj
  *  every input combination: A = 0..7, B = 0..7 (bit = 0 -> 0 V, 1 -> VDD)
  let ia = 0
  while ia < 8
    let ka0 = ia - 2*floor(ia/2)
    let ka1 = floor(ia/2) - 2*floor(ia/4)
    let ka2 = floor(ia/4)
    let va = ka0*vdd
    alter va0 dc = $&va
    let va = ka1*vdd
    alter va1 dc = $&va
    let va = ka2*vdd
    alter va2 dc = $&va
    let ib = 0
    while ib < 8
      let kb0 = ib - 2*floor(ib/2)
      let kb1 = floor(ib/2) - 2*floor(ib/4)
      let kb2 = floor(ib/4)
      let vb = kb0*vdd
      alter vb0 dc = $&vb
      let vb = kb1*vdd
      alter vb1 dc = $&vb
      let vb = kb2*vdd
      alter vb2 dc = $&vb
      op
      let leak = -i(vsup)
      let vg0b = v(xcla.g0_bar)
      let vg0  = v(xcla.g0)
      let vg1b = v(xcla.g1_bar)
      let vg1  = v(xcla.g1)
      let vg2b = v(xcla.g2_bar)
      let vg2  = v(xcla.g2)
      let vp1  = v(xcla.p1)
      let vp2  = v(xcla.p2)
      let vt1b = v(xcla.t1_bar)
      let vc2  = v(xcla.c2)
      let vt2b = v(xcla.t2_bar)
      let vt3  = v(xcla.t3)
      let vp21 = v(xcla.p21)
      let vt4  = v(xcla.t4)
      let vs0  = v(s0)
      let vs1  = v(s1)
      let vs2  = v(s2)
      let vco  = v(cout)
      echo "$&c,$&ia,$&ib,$&ka2,$&ka1,$&ka0,$&kb2,$&kb1,$&kb0,$&vdd,$&temp,$&n_vth0,$&n_toxe,$&n_ndep,$&n_u0,$&n_xj,$&p_vth0,$&p_toxe,$&p_ndep,$&p_u0,$&p_xj,$&leak,$&vg0b,$&vg0,$&vg1b,$&vg1,$&vg2b,$&vg2,$&vp1,$&vp2,$&vt1b,$&vc2,$&vt2b,$&vt3,$&vp21,$&vt4,$&vs0,$&vs1,$&vs2,$&vco" >> ../data/cla3.csv
      destroy all
      let ib = ib + 1
    end
    let ia = ia + 1
  end
  let c = c + 1
end
.endc
.end
