* INV - Part B SPICE reference: every input combination at the 200 shared corners
* Model: 22nm_HP.pm (PTM HP 22nm), VDD = 1 V   Corners: corners.inc (gen_corners.py, seed 12)
* Run:  ngspice_con -b inv_ngspice.cir   -> writes inv.csv
* Leakage = current drawn from the VDD supply (Vsup). Inputs are ideal sources at exactly 0 or VDD.
.options gmin=1e-18 abstol=1e-18 reltol=1e-6 vntol=1e-9
.include 22nm_HP.pm
.include corners.inc

* ---- supply and inputs ----
Vsup vdd 0 dc 1
Va a 0 dc 0
* ---- INV: A -> out ----
* transistor widths: NMOS 44n (2L), PMOS 88n (4L)
Mp out a vdd vdd pmos L=22n W=88n
Mn out a 0   0   nmos L=22n W=44n

.control
echo "corner,A,vdd,temp,n_vth0,n_toxe,n_ndep,n_u0,n_xj,p_vth0,p_toxe,p_ndep,p_u0,p_xj,leak,v_out" > inv.csv
let c = 0
while c < 200
  * ---- read corner c ----
  let vdd    = c_vdd[c]
  let temp   = c_temp[c]
  let n_vth0 = c_n_vth0[c]
  let n_toxe = c_n_toxe[c]
  let n_ndep = c_n_ndep[c]
  let n_u0   = c_n_u0[c]
  let n_xj   = c_n_xj[c]
  let p_vth0 = c_p_vth0[c]
  let p_toxe = c_p_toxe[c]
  let p_ndep = c_p_ndep[c]
  let p_u0   = c_p_u0[c]
  let p_xj   = c_p_xj[c]
  * ---- apply it: all NMOS share one set, all PMOS share another ----
  alter vsup dc = $&vdd
  option temp = $&temp
  altermod nmos vth0 = $&n_vth0 toxe = $&n_toxe ndep = $&n_ndep u0 = $&n_u0 xj = $&n_xj
  altermod pmos vth0 = $&p_vth0 toxe = $&p_toxe ndep = $&p_ndep u0 = $&p_u0 xj = $&p_xj
  * ---- every input combination (0 = 0 V, 1 = VDD) ----
  let ia = 0
  while ia < 2
    let va = ia*vdd
    alter va dc = $&va
    op
    let leak = -i(vsup)
    let vout = v(out)
    echo "$&c,$&ia,$&vdd,$&temp,$&n_vth0,$&n_toxe,$&n_ndep,$&n_u0,$&n_xj,$&p_vth0,$&p_toxe,$&p_ndep,$&p_u0,$&p_xj,$&leak,$&vout" >> inv.csv
    destroy all
    let ia = ia + 1
  end
  let c = c + 1
end
.endc
.end
