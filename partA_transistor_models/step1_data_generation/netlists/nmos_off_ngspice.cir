* NMOS OFF - dataset generation entirely inside ngspice
* Model: 22nm_HP.pm (PTM HP 22nm)
* Run:  ngspice_con -b nmos_off_ngspice.cir   -> writes ../data/nmos_off.csv
.options gmin=1e-18 abstol=1e-18 reltol=1e-6 vntol=1e-9
.include ../../../model/22nm_HP.pm

Vd d 0 dc 0
Vg g 0 dc 0
Vs s 0 dc 0
Vb b 0 dc 0
M1 d g s b nmos L=22n W=44n

.control
set rndseed=12
let n = 10000                    $ number of samples
echo "vdd,temp,w,vd,vs,vg,vb,vth0,toxe,ndep,u0,xj,id,ig,is,ib" > ../data/nmos_off.csv
let k = 0
while k < n
  * ---- assigned / nominal values (NMOS values from 22nm_HP.pm) ----
  let lmin = 22e-9
  let vdd_nom = 1.0              $ assigned nominal VDD = 1 V
  let vth0_nom = 0.50308
  let toxe_nom = 1.05e-9
  let ndep_nom = 5.5e18
  let u0_nom = 0.04
  let xj_nom = 7.2e-9
  * ---- draw one random sample (sunif(0) is uniform in -1..1) ----
  let vdd = vdd_nom*(1 + 0.1*sunif(0))
  let t = 42.5 + 82.5*sunif(0)
  let w = lmin*(4.5 + 3.5*sunif(0))
  let vd = vdd*(0.5 + 0.5*sunif(0))
  let vs = vdd*(0.5 + 0.5*sunif(0))
  let vg = 0
  let vb = 0
  let p1 = vth0_nom*(1 + 0.1*sunif(0))
  let p2 = toxe_nom*(1 + 0.1*sunif(0))
  let p3 = ndep_nom*(1 + 0.1*sunif(0))
  let p4 = u0_nom*(1 + 0.1*sunif(0))
  let p5 = xj_nom*(1 + 0.1*sunif(0))
  * ---- apply the sample to the circuit ----
  alter vd dc = $&vd
  alter vs dc = $&vs
  alter vg dc = $&vg
  alter vb dc = $&vb
  alter m1 w = $&w
  * one parameter per altermod line (ngspice applies only the first parameter on a line)
  altermod nmos vth0 = $&p1
  altermod nmos toxe = $&p2
  altermod nmos ndep = $&p3
  altermod nmos u0 = $&p4
  altermod nmos xj = $&p5
  option temp = $&t
  * ---- simulate and append one CSV row (currents INTO each terminal) ----
  op
  let cid = -i(vd)
  let cig = -i(vg)
  let cis = -i(vs)
  let cib = -i(vb)
  echo "$&vdd,$&t,$&w,$&vd,$&vs,$&vg,$&vb,$&p1,$&p2,$&p3,$&p4,$&p5,$&cid,$&cig,$&cis,$&cib" >> ../data/nmos_off.csv
  destroy all
  let k = k + 1
end
.endc
.end
