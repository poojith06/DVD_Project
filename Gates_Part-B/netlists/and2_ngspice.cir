* AND2 - Part B SPICE reference: every input combination at the 200 shared corners
* Model: 22nm_HP.pm (PTM HP 22nm), VDD = 1 V   Corners: corners.inc (gen_corners.py, seed 12)
* Run:  ngspice_con -b and2_ngspice.cir   -> writes and2.csv
* Leakage = current drawn from the VDD supply (Vsup). Inputs are ideal sources at exactly 0 or VDD.
.options gmin=1e-18 abstol=1e-18 reltol=1e-6 vntol=1e-9
.include 22nm_HP.pm
.include corners.inc

* ---- supply and inputs ----
Vsup vdd 0 dc 1
Va a 0 dc 0
Vb b 0 dc 0
* ---- AND2 = NAND2 (output n, internal node x) + INV (n -> out), simulated as one gate ----
* transistor widths: NAND2 part NMOS 88n, PMOS 88n, INV NMOS 44n, PMOS 88n
Mpa n   a vdd vdd pmos L=22n W=88n
Mpb n   b vdd vdd pmos L=22n W=88n
Mna n   a x   0   nmos L=22n W=88n
Mnb x   b 0   0   nmos L=22n W=88n
Mpi out n vdd vdd pmos L=22n W=88n
Mni out n 0   0   nmos L=22n W=44n

.control
echo "corner,A,B,vdd,temp,n_vth0,n_toxe,n_ndep,n_u0,n_xj,p_vth0,p_toxe,p_ndep,p_u0,p_xj,leak,v_int,v_n,v_out" > and2.csv
let c = 0
while c < 200
  * ---- read corner c ----
  let vdd    = c_vdd[c]
  let temp   = c_temp[c]
  let n_vth0 = c_n_vth0[c]
  let n_toxe = c_n_toxe[c]
  let n_ndep = c_n_ndep[c]
  let n_u0   = c_n_u0[c]
  let n_xj   = c_n_xj[c]
  let p_vth0 = c_p_vth0[c]
  let p_toxe = c_p_toxe[c]
  let p_ndep = c_p_ndep[c]
  let p_u0   = c_p_u0[c]
  let p_xj   = c_p_xj[c]
  * ---- apply it: all NMOS share one set, all PMOS share another ----
  alter vsup dc = $&vdd
  option temp = $&temp
  altermod nmos vth0 = $&n_vth0 toxe = $&n_toxe ndep = $&n_ndep u0 = $&n_u0 xj = $&n_xj
  altermod pmos vth0 = $&p_vth0 toxe = $&p_toxe ndep = $&p_ndep u0 = $&p_u0 xj = $&p_xj
  * ---- every input combination (0 = 0 V, 1 = VDD) ----
  let ia = 0
  while ia < 2
    let ib = 0
    while ib < 2
      let va = ia*vdd
      alter va dc = $&va
      let vb = ib*vdd
      alter vb dc = $&vb
      op
      let leak = -i(vsup)
      let vint = v(x)
      let vn = v(n)
      let vout = v(out)
      echo "$&c,$&ia,$&ib,$&vdd,$&temp,$&n_vth0,$&n_toxe,$&n_ndep,$&n_u0,$&n_xj,$&p_vth0,$&p_toxe,$&p_ndep,$&p_u0,$&p_xj,$&leak,$&vint,$&vn,$&vout" >> and2.csv
      destroy all
      let ib = ib + 1
    end
    let ia = ia + 1
  end
  let c = c + 1
end
.endc
.end
